* --- Models (defaults) ---
.model Diode D
.model QECL NPN(Is=0.26fA Bf=100 Br=1 Tf=0.1ns Cje=1pF Cjc=1.5pF Va=100)
.model Q2N3906	PNP(Is=1.41f Xti=3 Eg=1.11 Vaf=18.7 Bf=180.7 Ne=1.5 Ise=0
+		Ikf=80m Xtb=1.5 Br=4.977 Nc=2 Isc=0 Ikr=0 Rc=2.5 Cjc=9.728p
+		Mjc=.5776 Vjc=.75 Fc=.5 Cje=8.063p Mje=.3677 Vje=.75 Tr=33.42n
+		Tf=179.3p Itf=.4 Vtf=4 Xtf=6 Rb=10)

* --- Sources ---
V1   VCC   9     0

* --- Left bias leg (80k - D1 - 40k) feeding Q1 base (VB1) ---
R2   VCC   VB1   80k
R1   P001  0     40k
D1   P001  VB1   Diode         ; anode=P001, cathode=VB1

* --- Top diode leg (2k - D2) feeding node VC1 (Q1 C / Q2 B) ---
R7   VCC   N001  2k
D2   N001  VC1   Diode         ; anode=N001, cathode=VC1

* --- Transistors ---
Q1   VC1   VB1   VE1   0  QECL   ; Q1: NPN, C=VC1, B=VB1, E=VE1
Q2   VC2   VC1   VE2   0  Q2N3906	     ; Q2: PNP, C=VC2, B=VC1, E=VE2

* --- Resistors per figure ---
R3   VE2   VE1   2k             ; the feedback R between emitters
R4   VE1   0     2k             ; Q1 emitter to ground
R6   VE2   VCC   100            ; Q2 emitter to +9 V
R5   VC2   0     100            ; Q2 collector to ground

* --- Analysis ---
.op
.end
