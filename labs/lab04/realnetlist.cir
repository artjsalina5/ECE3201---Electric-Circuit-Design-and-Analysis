****** Lab 4 2N3904 Simulation ******
****** Author: A. Salinas ***********
****** Date: September 19, 2025*****

Q1 RC N004 0 0 2N3904
VCC N002 0 DC=15
RB N004 N003 R=390000
RC N002 RC R=1000
VBB N001 0 DC=25.3
RB1 N001 N003 R=10000
RB2 N003 0 R=10000
.model 2N3904 NPN(IS=1e-14 VAF=100 Bf=300 IKF=0.4 XTB=1.5 BR=4 CJC=4e-12 CJE=8e-12 RB=20 RC=0.1 RE=0.1 TR=2.5e-07 TF=3.5e-10 ITF=1 VTF=2 XTF=3 Vceo=40 Icrating=0.2 mfg="NXP")

.save V(n004) V(n001) V(n003) V(rc) V(n002) I(Q1) I(VCC) I(RB1) I(RB2) I(RB)
+ I(RC) I(VBB)
.end
